geiger2 exploratory HV supply - NOT a vendor-model signoff
* Parameter overrides are generated by scripts/simulate_hv.py.
.param VBAT=2.4 LVAL=1m DCR=8 CW=10n FREQ=10000 TON=20u ILOAD=1u
Vbat battery 0 {VBAT}
Rbat battery vin 0.5
Cin vin 0 22u ic=0
Rcoil vin coil {DCR}
L1 coil sw {LVAL} ic=0
Smain sw 0 gate 0 POWER
Coss sw 0 30p
Dbody 0 sw DFAST
.model POWER SW(Ron=2 Roff=1e10 Vt=0.5 Vh=0)
.model DFAST D(Is=2n N=1.7 Rs=2 Cjo=2p Tt=50n Bv=250 Ibv=1u)
* Four CW stages, one stage = two diodes and two capacitors.
C1 sw p1 {CW} ic=0
D1 0 p1 DFAST
D2 p1 s1 DFAST
C2 s1 0 {CW} ic=0
C3 p1 p2 {CW} ic=0
D3 s1 p2 DFAST
D4 p2 s2 DFAST
C4 s2 s1 {CW} ic=0
C5 p2 p3 {CW} ic=0
D5 s2 p3 DFAST
D6 p3 s3 DFAST
C6 s3 s2 {CW} ic=0
C7 p3 p4 {CW} ic=0
D7 s3 p4 DFAST
D8 p4 hv DFAST
C8 hv s3 {CW} ic=0
* Separate always-connected monitor divider; comparator senses it ideally.
Rtop1 hv div1 33Meg
Rtop2 div1 div2 33Meg
Rtop3 div2 div3 33Meg
Rtop4 div3 sense 33Meg
Rbottom sense 0 412k
Csense sense 0 100p ic=0
* Soft load turn-on prevents nonphysical negative output at t=0.
Bload hv 0 I={ILOAD*max(0,min(1,v(hv)/100))}
* Behavioral comparator: 1.242 V reference, 8 mV total input hysteresis.
* 40 us output time constant is a conservative behavioral assumption.
Vlogic logic 0 1
Rpull logic enable 10k
Sinhibit enable 0 sense 0 HYST OFF
.model HYST SW(Ron=1 Roff=1e12 Vt=1.242 Vh=0.004)
Rdelay enable delayed 10k
Cdelay delayed 0 4n ic=1
Vclock clock 0 PULSE(0 1 0 50n 50n {TON} {1/FREQ})
Bgate gate 0 V={v(clock)*(v(delayed)>0.5)}
.options method=gear reltol=0.001 abstol=1p vntol=1u
.control
set wr_singlescale
set wr_vecnames
tran 10u 0.3 0 2u uic
wrdata metrics.txt v(hv) v(sw) i(L1) i(Vbat)
linearize v(hv) v(sw) i(L1) i(Vbat) v(sense) v(gate) v(s1) v(s2) v(s3)
wrdata wave.txt v(hv) v(sw) i(L1) i(Vbat) v(sense) v(gate) v(s1) v(s2) v(s3)
quit
.endc
.end
